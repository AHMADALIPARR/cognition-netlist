`include "constants.vams"
`include "disciplines.vams"

// =============================================================================
// cognitive_poly_cell.va
// Verilog-A polynomial cubic cell for analog gradient-flow memory wells
// Implements the cubic ODE cell used as a continuous F2 memory element.
// =============================================================================

module cognitive_poly_cell(state, stimulus);
    output state;
    input stimulus;

    electrical state, stimulus;

    parameter real cap = 1e-9;
    parameter real a = -1e-6;
    parameter real b = 1e-6;
    parameter real gain = 1e-6;

    analog begin
        I(state) <+ cap * ddt(V(state));
        I(state) <+ a * V(state);
        I(state) <+ b * V(state) *
                      V(state) * V(state);
        I(state) <+ -gain * V(stimulus);
    end
endmodule
